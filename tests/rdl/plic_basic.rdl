// PLIC fixture — 8-source, 1-context baseline.
//
// Layout mirrors the SiFive Platform-Level Interrupt Controller:
//
//   0x0000..0x001C   priority[0..7]  — 3-bit per-source priority
//                                       (source 0 is reserved / "no-source")
//   0x1000           pending         — bitmap, bit i = source i pending
//   0x2000           enable          — bitmap, bit i = source i enabled
//   0x200000         threshold       — only priority > threshold fires
//   0x200004         claim_complete  — read → claim (returns winner ID,
//                                       marks that source "in service");
//                                      write → complete (clears the
//                                       in-service bit for the written ID).
//
// v2 scope:
//   * N = 8 sources (bit 0 unused, bits [8:1] carry real sources).
//   * 1 M-mode context — drives one bit of `intr_out` (→ mip.meip).
//   * Level-triggered. The logic module passes `source_in` into the
//     pending register each cycle; no edge detection.
//   * Spec-compliant claim / complete. Reading the claim reg latches an
//     "in-service" bit that masks the source from further arbitration
//     on this context; writing the ID to the same reg releases it.
//     Built on the upstream rdl2arch `emit_read_pulse` /
//     `emit_write_pulse` UDPs so the logic module sees a 1-cycle pulse
//     on each SW access.
//
// Edge detection and S-mode delegation are scoped to follow-up phases.

addrmap plic {
    reg {
        riscv_intr_plic_role = "priority";
        field { sw = rw; hw = r; reset = 0x0; } value[2:0];
        field { sw = r;  hw = r; reset = 0x0; } reserved[31:3];
    } priority[9] @ 0x0000;  // 9 entries for sources 0..8

    reg {
        riscv_intr_plic_role = "pending";
        field { sw = r; hw = w; reset = 0x0; } value[8:0];
        field { sw = r; hw = r; reset = 0x0; } reserved[31:9];
    } pending @ 0x1000;

    reg {
        riscv_intr_plic_role = "enable";
        field { sw = rw; hw = r; reset = 0x0; } value[8:0];
        field { sw = r;  hw = r; reset = 0x0; } reserved[31:9];
    } enable_0 @ 0x2000;

    reg {
        riscv_intr_plic_role = "threshold";
        field { sw = rw; hw = r; reset = 0x0; } value[2:0];
        field { sw = r;  hw = r; reset = 0x0; } reserved[31:3];
    } threshold_0 @ 0x200000;

    // Combined claim / complete register. Read returns the current
    // winner ID (HW drives it each cycle via hwif_in); write deposits
    // the complete ID into storage for one cycle so the logic module
    // can latch it. Both sides need to write storage, hence sw=rw; hw=rw.
    reg {
        riscv_intr_plic_role = "claim";
        emit_read_pulse  = true;
        emit_write_pulse = true;
        field { sw = rw; hw = rw; reset = 0x0; } value[3:0];
        field { sw = r;  hw = r;  reset = 0x0; } reserved[31:4];
    } claim_0 @ 0x200004;
};
