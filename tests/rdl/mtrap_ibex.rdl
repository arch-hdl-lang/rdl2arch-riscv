// Phase-6.5 progressive M-trap CSR fixture — the set of CSRs we've
// migrated out of Ibex's `ibex_cs_registers.sv` and onto our generated
// `CsrFile`. Grows across Phase-6.5 sub-phases:
//
//   6.5a — mscratch              (plain RW, no side-effects)
//   6.5b — + mtvec               (plain RW; exported via csr_mtvec_o)
//   6.5c — + mepc/mcause/mtval   (HW-written on trap entry — our
//                                 generated CsrTrapCoord bridges
//                                 Ibex's `csr_save_cause_i` pulse
//                                 into the CsrFile's hwif_in)
//   6.5d — + mstatus             (auto-clear `mie` on trap; restore
//                                 `mie`←`mpie`, `mpie`←1, `mpp`←U
//                                 on mret. We model only the three
//                                 fields Ibex exposes to its
//                                 controller (mie / mpie / mpp);
//                                 mprv / tw aren't wired in our
//                                 M-only SoC so they stay absent
//                                 from the fixture.)
//   6.5e — + mie/mip             (mip is combinational mirror of
//                                 live IRQ lines)
//
// Anything not yet in this fixture stays on Ibex's native path inside
// the forked `ibex_cs_registers_hybrid.sv`.

addrmap m_trap_ibex {
    default riscv_priv = "m";

    reg {
        // mstatus, M-only subset. We model only the three interrupt-
        // relevant fields (mie / mpie / mpp). mprv / tw would need
        // U-mode support on the core side to matter.
        //
        // Reserved fields are emitted as sw=r;hw=w WPRI so the
        // generator still places them in the register image (read as
        // 0, writes discarded). Our hybrid adapter ties the hwif_in
        // drivers for these reserved bits to zero.
        riscv_csr_addr = 0x300;
        field { sw = rw; hw = r;  reset = 0x0; riscv_wpri = true; } wpri_lo[0:0];
        field { sw = r;  hw = w;  reset = 0x0; riscv_wpri = true; } reserved_2_1[2:1];
        field { sw = rw; hw = rw; reset = 0x0;                    } mie[3:3];
        field { sw = r;  hw = w;  reset = 0x0; riscv_wpri = true; } reserved_6_4[6:4];
        field { sw = rw; hw = rw; reset = 0x0;
                riscv_save_on_trap = true; riscv_restore_on_ret = true; } mpie[7:7];
        field { sw = r;  hw = w;  reset = 0x0; riscv_wpri = true; } reserved_10_8[10:8];
        field { sw = rw; hw = rw; reset = 0x0;
                riscv_warl = "0x3";
                riscv_save_on_trap = true; riscv_restore_on_ret = true; } mpp[12:11];
        field { sw = r;  hw = w;  reset = 0x0; riscv_wpri = true; } wpri_hi[31:13];
    } mstatus @ 0x18;

    reg {
        // mtvec. Kept with a lean WARL profile for now: mode is a 2-bit
        // enum legal for {direct (0), vectored (1)}; base is 30 bits.
        //
        // Ibex's hardware always forces `mtvec.MODE = 01` (vectored).
        // Our generated WARL accepts either value and preserves it —
        // SW setting mtvec to an aligned trap_entry address lands
        // mode=0 (direct). Functionally fine in this hybrid because
        // our vector table at `trap_entry` is 32 copies of
        // `j common_trap_handler`, so direct-mode dispatch still hits
        // the same entry. See `tests/cpu/sw/*.S` + cs_registers_hybrid
        // comments.
        riscv_csr_addr = 0x305;
        field { sw = rw; hw = r; reset = 0x0;
                riscv_warl = "0,1"; } mode[1:0];
        field { sw = rw; hw = r; reset = 0x0; } base[31:2];
    } mtvec @ 0x4;

    reg {
        // mepc: WARL bitmask masks bit 0 to zero (RV32 IALIGN=32).
        // Ibex already drives only aligned PCs into `exception_pc`, so
        // the HW-save path never tries to write an odd value — the
        // bitmask is there for direct SW writes via `csrw mepc, ...`.
        riscv_csr_addr = 0x341;
        field { sw = rw; hw = rw; reset = 0x0;
                riscv_warl = "0xFFFFFFFE";
                riscv_save_on_trap = true; } epc[31:0];
    } mepc @ 0x8;

    reg {
        // mcause: RISC-V spec encodes `{interrupt, 0s, cause[4:0]}`
        // across all 32 bits. Ibex's internal packed `exc_cause_t`
        // splits `(irq_ext, irq_int, lower_cause)`; the adapter in
        // `ibex_cs_registers_hybrid.sv` re-encodes that into the flat
        // 32-bit shape our CsrFile stores before driving hwif_in.
        riscv_csr_addr = 0x342;
        field { sw = rw; hw = rw; reset = 0x0;
                riscv_save_on_trap = true; } cause[31:0];
    } mcause @ 0xC;

    reg {
        riscv_csr_addr = 0x343;
        field { sw = rw; hw = rw; reset = 0x0;
                riscv_save_on_trap = true; } tval[31:0];
    } mtval @ 0x10;

    reg {
        riscv_csr_addr = 0x340;
        field { sw = rw; hw = r; reset = 0x0; } value[31:0];
    } mscratch @ 0x14;
};
