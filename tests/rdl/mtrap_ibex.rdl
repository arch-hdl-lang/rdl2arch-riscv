// Phase-6.5 progressive M-trap CSR fixture — the set of CSRs we've
// migrated out of Ibex's `ibex_cs_registers.sv` and onto our generated
// `CsrFile`. Grows across Phase-6.5 sub-phases:
//
//   6.5a — mscratch              (plain RW, no side-effects)
//   6.5b — + mtvec               (plain RW; exported via csr_mtvec_o)
//   6.5c — + mepc/mcause/mtval   (HW-written on trap entry — our
//                                 generated CsrTrapCoord bridges
//                                 Ibex's `csr_save_cause_i` pulse
//                                 into the CsrFile's hwif_in)
//   6.5d — + mstatus             (auto-clear `mie` on trap; restore
//                                 `mie`←`mpie`, `mpie`←1, `mpp`←U
//                                 on mret. We model only the three
//                                 fields Ibex exposes to its
//                                 controller (mie / mpie / mpp);
//                                 mprv / tw aren't wired in our
//                                 M-only SoC so they stay absent
//                                 from the fixture.)
//   6.5e — + mie / mip           (SW-writable interrupt enable
//                                 bits; mip bits are HW-driven
//                                 mirrors of the CLINT / PLIC
//                                 irq lines. For the Ibex
//                                 controller's combinational
//                                 `irqs_o = mip & mie` path, the
//                                 adapter taps live irq_* wires +
//                                 `hwif_out.mie_*` directly —
//                                 SW-observable mip storage is
//                                 1-cycle lagged, which is fine
//                                 for `csrr t0, mip` inside a
//                                 handler.)
//   6.6a — + mcountinhibit       (plain RW. Bits: cy (0) + ir (2)
//                                 gate mcycle / minstret; HPM
//                                 bits [12:3] gate the optional
//                                 HPM counters 3..12 that our
//                                 Ibex config (MHPMCounterNum=10)
//                                 still keeps on upstream's path.
//                                 Bit 1 / bits [31:13] are WPRI.
//                                 The adapter consumes the whole
//                                 register as a 32-bit view via
//                                 `hwif_out.mcountinhibit_rdata_flat`
//                                 — the HPM counter increment
//                                 blocks still reference
//                                 `mcountinhibit[N]` unchanged.)
//   6.6b — + mcycle / mcycleh    (the cycle-counter pair, 64-bit
//                                 logical counter split across two
//                                 32-bit CSRs. Uses the new
//                                 `riscv_hw_increment_when` UDP to
//                                 name an external enable port
//                                 `cycle_en` on the CsrFile — the
//                                 adapter wires `cycle_en =
//                                 ~mcountinhibit[0]`, so SW can
//                                 freeze the counter via the cy
//                                 inhibit bit. `minstret` /
//                                 `minstreth` intentionally stay
//                                 on Ibex's native path because of
//                                 the core's speculative-retire +1
//                                 optimization — pipeline-specific
//                                 and doesn't belong in the
//                                 generator.)
//   6.7  — + dcsr / dpc / dscratch0 / dscratch1
//                                (the four M-mode debug CSRs that
//                                 Ibex always instantiates. In our
//                                 `DbgTriggerEn=0` build the debug
//                                 trigger regs stay absent and no
//                                 HW debug-entry happens, so the
//                                 fields are modelled as SW-RW
//                                 storage with spec-correct WPRI +
//                                 WARL. dcsr.prv is WARL {0 (U),
//                                 3 (M)} — SW writes of 1/2
//                                 legalize to 0, matching Ibex.
//                                 The debug-mode access check
//                                 (`dbg_csr` flag upstream raises
//                                 on decode) stays in the adapter
//                                 — it's address-decoding, not
//                                 storage.)
//   6.8  — + mhpmcounter3..12 / mhpmcounter3h..12h / mhpmevent3..12
//                                (HPM counter block for our
//                                 `MHPMCounterNum=10` Ibex config.
//                                 Counter pairs use the same
//                                 `riscv_hw_increment_when` /
//                                 `riscv_hw_increment_high_of` UDPs
//                                 as mcycle/mcycleh from 6.6b;
//                                 each counter N has its own
//                                 enable port `hpm<N>_inc_en` wired
//                                 in the adapter to `mhpmcounter_incr[N]
//                                 & ~mcountinhibit[N]`. `mhpmevent<N>`
//                                 are `sw=r;hw=r` RO constants with
//                                 reset `1 << (N - 3)` — matching
//                                 Ibex's hardwired event-selector
//                                 encoding.)
//
// Anything not yet in this fixture stays on Ibex's native path inside
// the forked `ibex_cs_registers_hybrid.sv`.

addrmap m_trap_ibex {
    default riscv_priv = "m";

    reg {
        // mstatus, M-only subset. We model only the three interrupt-
        // relevant fields (mie / mpie / mpp). mprv / tw would need
        // U-mode support on the core side to matter.
        //
        // Reserved fields are emitted as sw=r;hw=w WPRI so the
        // generator still places them in the register image (read as
        // 0, writes discarded). Our hybrid adapter ties the hwif_in
        // drivers for these reserved bits to zero.
        riscv_csr_addr = 0x300;
        field { sw = rw; hw = r;  reset = 0x0; riscv_wpri = true; } wpri_lo[0:0];
        field { sw = r;  hw = w;  reset = 0x0; riscv_wpri = true; } reserved_2_1[2:1];
        // mie: the live mstatus.MIE bit. HW-writable for two reasons —
        // auto-clear on trap entry (`hwif_in_live` in the adapter) and
        // restore on mret (`riscv_restore_on_ret` — the TrapCoord drives
        // `hwif_in_drive.mstatus_mie ← restore_mstatus_mie` on
        // `xret_enter`; the adapter sources that port from
        // `hwif_out.mstatus_mpie`).
        field { sw = rw; hw = rw; reset = 0x0;
                riscv_restore_on_ret = true; } mie[3:3];
        field { sw = r;  hw = w;  reset = 0x0; riscv_wpri = true; } reserved_6_4[6:4];
        field { sw = rw; hw = rw; reset = 0x0;
                riscv_save_on_trap = true; riscv_restore_on_ret = true; } mpie[7:7];
        field { sw = r;  hw = w;  reset = 0x0; riscv_wpri = true; } reserved_10_8[10:8];
        field { sw = rw; hw = rw; reset = 0x0;
                riscv_warl = "0x3";
                riscv_save_on_trap = true; riscv_restore_on_ret = true; } mpp[12:11];
        field { sw = r;  hw = w;  reset = 0x0; riscv_wpri = true; } wpri_hi[31:13];
    } mstatus @ 0x18;

    reg {
        // mtvec. Kept with a lean WARL profile for now: mode is a 2-bit
        // enum legal for {direct (0), vectored (1)}; base is 30 bits.
        //
        // Ibex's hardware always forces `mtvec.MODE = 01` (vectored).
        // Our generated WARL accepts either value and preserves it —
        // SW setting mtvec to an aligned trap_entry address lands
        // mode=0 (direct). Functionally fine in this hybrid because
        // our vector table at `trap_entry` is 32 copies of
        // `j common_trap_handler`, so direct-mode dispatch still hits
        // the same entry. See `tests/cpu/sw/*.S` + cs_registers_hybrid
        // comments.
        riscv_csr_addr = 0x305;
        field { sw = rw; hw = r; reset = 0x0;
                riscv_warl = "0,1"; } mode[1:0];
        field { sw = rw; hw = r; reset = 0x0; } base[31:2];
    } mtvec @ 0x4;

    reg {
        // mepc: WARL bitmask masks bit 0 to zero (RV32 IALIGN=32).
        // Ibex already drives only aligned PCs into `exception_pc`, so
        // the HW-save path never tries to write an odd value — the
        // bitmask is there for direct SW writes via `csrw mepc, ...`.
        riscv_csr_addr = 0x341;
        field { sw = rw; hw = rw; reset = 0x0;
                riscv_warl = "0xFFFFFFFE";
                riscv_save_on_trap = true; } epc[31:0];
    } mepc @ 0x8;

    reg {
        // mcause: RISC-V spec encodes `{interrupt, 0s, cause[4:0]}`
        // across all 32 bits. Ibex's internal packed `exc_cause_t`
        // splits `(irq_ext, irq_int, lower_cause)`; the adapter in
        // `ibex_cs_registers_hybrid.sv` re-encodes that into the flat
        // 32-bit shape our CsrFile stores before driving hwif_in.
        riscv_csr_addr = 0x342;
        field { sw = rw; hw = rw; reset = 0x0;
                riscv_save_on_trap = true; } cause[31:0];
    } mcause @ 0xC;

    reg {
        riscv_csr_addr = 0x343;
        field { sw = rw; hw = rw; reset = 0x0;
                riscv_save_on_trap = true; } tval[31:0];
    } mtval @ 0x10;

    reg {
        riscv_csr_addr = 0x340;
        field { sw = rw; hw = r; reset = 0x0; } value[31:0];
    } mscratch @ 0x14;

    reg {
        // mie — SW-written interrupt enables. HW never writes, so
        // the adapter doesn't need a hwif_in drive for these fields;
        // our CsrFile stores whatever SW last wrote.
        //
        // We model only the bits the Ibex controller checks in our
        // SoC: MSIE (3), MTIE (7), MEIE (11), and the fast-IRQ 0 bit
        // (16) — that's the one we wired PLIC context-1 to in
        // Phase 6.4. Upper fast bits (17-30) plus the S-mode slots
        // aren't used, so they're WPRI.
        riscv_csr_addr = 0x304;
        field { sw = r;  hw = w; reset = 0x0; riscv_wpri = true; } wpri_0_0[0:0];
        field { sw = r;  hw = w; reset = 0x0; riscv_wpri = true; } wpri_2_1[2:1];
        field { sw = rw; hw = r; reset = 0x0; } msie[3:3];
        field { sw = r;  hw = w; reset = 0x0; riscv_wpri = true; } wpri_6_4[6:4];
        field { sw = rw; hw = r; reset = 0x0; } mtie[7:7];
        field { sw = r;  hw = w; reset = 0x0; riscv_wpri = true; } wpri_10_8[10:8];
        field { sw = rw; hw = r; reset = 0x0; } meie[11:11];
        field { sw = r;  hw = w; reset = 0x0; riscv_wpri = true; } wpri_15_12[15:12];
        field { sw = rw; hw = r; reset = 0x0; } mfie_0[16:16];
        field { sw = r;  hw = w; reset = 0x0; riscv_wpri = true; } wpri_hi[31:17];
    } mie @ 0x1C;

    reg {
        // mip — HW-driven pending bits. SW reads only (per the
        // standard M-mode interpretation — clearing is done by the
        // source device: CLINT.mtimecmp write for MTIP, PLIC claim
        // for MEIP, CLINT.msip write for MSIP).
        //
        // Each active bit carries `riscv_hw_mirror = true`, so the
        // generator emits a dedicated `mirror_mip_<field>: in UInt<1>`
        // port on the TrapCoord. The adapter wires those directly to
        // the live `irq_*_i` module inputs every cycle, so SW reads
        // see a one-cycle-lagged mirror. For the Ibex *controller's*
        // trap-decision path (`irqs_o = mip & mie_q` upstream), the
        // adapter taps irq_*_i directly — no storage in the middle —
        // so the trap-take latency matches upstream exactly.
        riscv_csr_addr = 0x344;
        field { sw = r; hw = w; reset = 0x0; riscv_wpri = true; } wpri_0_0[0:0];
        field { sw = r; hw = w; reset = 0x0; riscv_wpri = true; } wpri_2_1[2:1];
        field { sw = r; hw = w; reset = 0x0;
                riscv_hw_mirror = true; } msip[3:3];
        field { sw = r; hw = w; reset = 0x0; riscv_wpri = true; } wpri_6_4[6:4];
        field { sw = r; hw = w; reset = 0x0;
                riscv_hw_mirror = true; } mtip[7:7];
        field { sw = r; hw = w; reset = 0x0; riscv_wpri = true; } wpri_10_8[10:8];
        field { sw = r; hw = w; reset = 0x0;
                riscv_hw_mirror = true; } meip[11:11];
        field { sw = r; hw = w; reset = 0x0; riscv_wpri = true; } wpri_15_12[15:12];
        field { sw = r; hw = w; reset = 0x0;
                riscv_hw_mirror = true; } mfip_0[16:16];
        field { sw = r; hw = w; reset = 0x0; riscv_wpri = true; } wpri_hi[31:17];
    } mip @ 0x20;

    reg {
        // mcountinhibit — per-counter inhibit bits.
        //
        //   bit  0  cy   — inhibit mcycle
        //   bit  1  tm   — reserved (timer, not mcounter)
        //   bit  2  ir   — inhibit minstret
        //   bits 3..12   — inhibit mhpmcounter3..mhpmcounter12
        //                  (Ibex's MHPMCounterNum=10 on our config,
        //                   so 10 HPM counters are instantiated
        //                   upstream-side)
        //   bits 13..31  — WPRI
        //
        // The HPM counters themselves aren't migrated onto the
        // generator; only their inhibit control moves here. The
        // adapter drives `mcountinhibit` (the wire consumed by the
        // HPM increment-gating logic) from our CsrFile's flat
        // spec-layout view.
        riscv_csr_addr = 0x320;
        field { sw = rw; hw = r; reset = 0x0; } cy[0:0];
        field { sw = r;  hw = w; reset = 0x0; riscv_wpri = true; } reserved_tm[1:1];
        field { sw = rw; hw = r; reset = 0x0; } ir[2:2];
        field { sw = rw; hw = r; reset = 0x0; } hpm[12:3];
        field { sw = r;  hw = w; reset = 0x0; riscv_wpri = true; } reserved_hi[31:13];
    } mcountinhibit @ 0x24;

    reg {
        // mcycle — low 32 bits of the 64-bit cycle counter.
        //
        // `riscv_hw_increment_when = "cycle_en"` tells the generator
        // to emit a `cycle_en: in Bool` port on the CsrFile and add
        // a seq-block increment when that port is high. Fields must
        // be `hw = r` (no hwif_in) since storage is self-driven by
        // the increment; SW writes still land via the bus and take
        // priority on the same cycle via last-write-wins.
        riscv_csr_addr = 0xB00;
        field { sw = rw; hw = r; reset = 0x0;
                riscv_hw_increment_when = "cycle_en"; } value[31:0];
    } mcycle @ 0x28;

    reg {
        // mcycleh — high 32 bits. Linked via
        // `riscv_hw_increment_high_of = "mcycle"`; the generator
        // emits an increment on the cycle where the low half is at
        // max AND `cycle_en` is high (the rollover of a joint 64-bit
        // +1). SW can write either half independently.
        riscv_csr_addr = 0xB80;
        field { sw = rw; hw = r; reset = 0x0;
                riscv_hw_increment_high_of = "mcycle"; } value[31:0];
    } mcycleh @ 0x2C;

    reg {
        // dcsr — Debug Control and Status Register (CSR 0x7B0).
        //
        // Spec layout (RISC-V Debug Spec 0.13.2, M-only slice):
        //   [31:28] xdebugver   — RO const 0x4 (spec version).
        //   [27:18] reserved    — WPRI.
        //   [17:16] ebreakvs/vu — H-ext not present; WPRI.
        //   [15]    ebreakm     — SW RW.
        //   [14]    reserved    — WPRI.
        //   [13]    ebreaks     — S-mode not present; WPRI.
        //   [12]    ebreaku     — SW RW.
        //   [11]    stepie      — Ibex forces 0; WPRI.
        //   [10]    stopcount   — Ibex forces 0; WPRI.
        //   [9]     stoptime    — Ibex forces 0; WPRI.
        //   [8:6]   cause       — RO for SW; HW-written on debug
        //                         entry (never happens in our
        //                         DbgTriggerEn=0 build, so storage
        //                         holds its reset 0).
        //   [5]     reserved    — WPRI.
        //   [4]     mprven      — Ibex forces 0; WPRI.
        //   [3]     nmip        — RO for SW; HW-driven.
        //   [2]     step        — SW RW.
        //   [1:0]   prv         — WARL {0 (U), 3 (M)}. Resets to 3
        //                         (matches Ibex's DCSR_RESET_VAL so
        //                         the `dret` path's `priv_lvl_d <=
        //                         dcsr_q.prv` reads M at cold-boot).
        //                         SW writes of 1 or 2 legalize to 0.
        riscv_csr_addr = 0x7B0;
        field { sw = rw; hw = r; reset = 0x3;
                riscv_warl = "0,3"; } prv[1:0];
        field { sw = rw; hw = r; reset = 0x0; } step[2:2];
        field { sw = r;  hw = w; reset = 0x0; } nmip[3:3];
        field { sw = r;  hw = w; reset = 0x0; riscv_wpri = true; } mprven[4:4];
        field { sw = r;  hw = w; reset = 0x0; riscv_wpri = true; } reserved_5[5:5];
        field { sw = r;  hw = w; reset = 0x0; } cause[8:6];
        field { sw = r;  hw = w; reset = 0x0; riscv_wpri = true; } stoptime[9:9];
        field { sw = r;  hw = w; reset = 0x0; riscv_wpri = true; } stopcount[10:10];
        field { sw = r;  hw = w; reset = 0x0; riscv_wpri = true; } stepie[11:11];
        field { sw = rw; hw = r; reset = 0x0; } ebreaku[12:12];
        field { sw = r;  hw = w; reset = 0x0; riscv_wpri = true; } ebreaks[13:13];
        field { sw = r;  hw = w; reset = 0x0; riscv_wpri = true; } reserved_14[14:14];
        field { sw = rw; hw = r; reset = 0x0; } ebreakm[15:15];
        field { sw = r;  hw = w; reset = 0x0; riscv_wpri = true; } ebreakvu[16:16];
        field { sw = r;  hw = w; reset = 0x0; riscv_wpri = true; } ebreakvs[17:17];
        field { sw = r;  hw = w; reset = 0x0; riscv_wpri = true; } reserved_27_18[27:18];
        field { sw = r;  hw = r; reset = 0x4; } xdebugver[31:28];
    } dcsr @ 0x30;

    reg {
        // dpc — Debug Program Counter (CSR 0x7B1). Low bit zero
        // (IALIGN=32) like mepc. Ibex never writes it in our
        // DbgTriggerEn=0 build, so `hw = r` and no save-on-entry
        // tag — only SW reads / writes.
        riscv_csr_addr = 0x7B1;
        field { sw = rw; hw = r; reset = 0x0;
                riscv_warl = "0xFFFFFFFE"; } dpc[31:0];
    } dpc @ 0x34;

    reg {
        // dscratch0 / dscratch1 — Plain RW scratch for the debugger.
        // Nothing touches them on the HW side in our build.
        riscv_csr_addr = 0x7B2;
        field { sw = rw; hw = r; reset = 0x0; } value[31:0];
    } dscratch0 @ 0x38;

    reg {
        riscv_csr_addr = 0x7B3;
        field { sw = rw; hw = r; reset = 0x0; } value[31:0];
    } dscratch1 @ 0x3C;

    reg {
        // mhpmcounter3 — event counter: dside_wait (cycles waiting for data memory).
        riscv_csr_addr = 0xB03;
        field { sw = rw; hw = r; reset = 0x0;
                riscv_hw_increment_when = "hpm3_inc_en"; } value[31:0];
    } mhpmcounter3 @ 0x40;

    reg {
        // mhpmcounter3h — high half, links via
        // `riscv_hw_increment_high_of`.
        riscv_csr_addr = 0xB83;
        field { sw = rw; hw = r; reset = 0x0;
                riscv_hw_increment_high_of = "mhpmcounter3"; } value[31:0];
    } mhpmcounter3h @ 0x68;

    reg {
        // mhpmevent3 — RO selector; reads 0x1
        // (Ibex hardwires event = 1 << (counter_idx - 3)).
        riscv_csr_addr = 0x323;
        field { sw = r; hw = r; reset = 0x1; } value[31:0];
    } mhpmevent3 @ 0x90;

    reg {
        // mhpmcounter4 — event counter: iside_wait (cycles waiting for instruction fetches).
        riscv_csr_addr = 0xB04;
        field { sw = rw; hw = r; reset = 0x0;
                riscv_hw_increment_when = "hpm4_inc_en"; } value[31:0];
    } mhpmcounter4 @ 0x44;

    reg {
        // mhpmcounter4h — high half, links via
        // `riscv_hw_increment_high_of`.
        riscv_csr_addr = 0xB84;
        field { sw = rw; hw = r; reset = 0x0;
                riscv_hw_increment_high_of = "mhpmcounter4"; } value[31:0];
    } mhpmcounter4h @ 0x6C;

    reg {
        // mhpmevent4 — RO selector; reads 0x2
        // (Ibex hardwires event = 1 << (counter_idx - 3)).
        riscv_csr_addr = 0x324;
        field { sw = r; hw = r; reset = 0x2; } value[31:0];
    } mhpmevent4 @ 0x94;

    reg {
        // mhpmcounter5 — event counter: mem_load (number of loads).
        riscv_csr_addr = 0xB05;
        field { sw = rw; hw = r; reset = 0x0;
                riscv_hw_increment_when = "hpm5_inc_en"; } value[31:0];
    } mhpmcounter5 @ 0x48;

    reg {
        // mhpmcounter5h — high half, links via
        // `riscv_hw_increment_high_of`.
        riscv_csr_addr = 0xB85;
        field { sw = rw; hw = r; reset = 0x0;
                riscv_hw_increment_high_of = "mhpmcounter5"; } value[31:0];
    } mhpmcounter5h @ 0x70;

    reg {
        // mhpmevent5 — RO selector; reads 0x4
        // (Ibex hardwires event = 1 << (counter_idx - 3)).
        riscv_csr_addr = 0x325;
        field { sw = r; hw = r; reset = 0x4; } value[31:0];
    } mhpmevent5 @ 0x98;

    reg {
        // mhpmcounter6 — event counter: mem_store (number of stores).
        riscv_csr_addr = 0xB06;
        field { sw = rw; hw = r; reset = 0x0;
                riscv_hw_increment_when = "hpm6_inc_en"; } value[31:0];
    } mhpmcounter6 @ 0x4C;

    reg {
        // mhpmcounter6h — high half, links via
        // `riscv_hw_increment_high_of`.
        riscv_csr_addr = 0xB86;
        field { sw = rw; hw = r; reset = 0x0;
                riscv_hw_increment_high_of = "mhpmcounter6"; } value[31:0];
    } mhpmcounter6h @ 0x74;

    reg {
        // mhpmevent6 — RO selector; reads 0x8
        // (Ibex hardwires event = 1 << (counter_idx - 3)).
        riscv_csr_addr = 0x326;
        field { sw = r; hw = r; reset = 0x8; } value[31:0];
    } mhpmevent6 @ 0x9C;

    reg {
        // mhpmcounter7 — event counter: jump (unconditional jumps).
        riscv_csr_addr = 0xB07;
        field { sw = rw; hw = r; reset = 0x0;
                riscv_hw_increment_when = "hpm7_inc_en"; } value[31:0];
    } mhpmcounter7 @ 0x50;

    reg {
        // mhpmcounter7h — high half, links via
        // `riscv_hw_increment_high_of`.
        riscv_csr_addr = 0xB87;
        field { sw = rw; hw = r; reset = 0x0;
                riscv_hw_increment_high_of = "mhpmcounter7"; } value[31:0];
    } mhpmcounter7h @ 0x78;

    reg {
        // mhpmevent7 — RO selector; reads 0x10
        // (Ibex hardwires event = 1 << (counter_idx - 3)).
        riscv_csr_addr = 0x327;
        field { sw = r; hw = r; reset = 0x10; } value[31:0];
    } mhpmevent7 @ 0xA0;

    reg {
        // mhpmcounter8 — event counter: branch (conditional branches).
        riscv_csr_addr = 0xB08;
        field { sw = rw; hw = r; reset = 0x0;
                riscv_hw_increment_when = "hpm8_inc_en"; } value[31:0];
    } mhpmcounter8 @ 0x54;

    reg {
        // mhpmcounter8h — high half, links via
        // `riscv_hw_increment_high_of`.
        riscv_csr_addr = 0xB88;
        field { sw = rw; hw = r; reset = 0x0;
                riscv_hw_increment_high_of = "mhpmcounter8"; } value[31:0];
    } mhpmcounter8h @ 0x7C;

    reg {
        // mhpmevent8 — RO selector; reads 0x20
        // (Ibex hardwires event = 1 << (counter_idx - 3)).
        riscv_csr_addr = 0x328;
        field { sw = r; hw = r; reset = 0x20; } value[31:0];
    } mhpmevent8 @ 0xA4;

    reg {
        // mhpmcounter9 — event counter: branch_taken (taken conditional branches).
        riscv_csr_addr = 0xB09;
        field { sw = rw; hw = r; reset = 0x0;
                riscv_hw_increment_when = "hpm9_inc_en"; } value[31:0];
    } mhpmcounter9 @ 0x58;

    reg {
        // mhpmcounter9h — high half, links via
        // `riscv_hw_increment_high_of`.
        riscv_csr_addr = 0xB89;
        field { sw = rw; hw = r; reset = 0x0;
                riscv_hw_increment_high_of = "mhpmcounter9"; } value[31:0];
    } mhpmcounter9h @ 0x80;

    reg {
        // mhpmevent9 — RO selector; reads 0x40
        // (Ibex hardwires event = 1 << (counter_idx - 3)).
        riscv_csr_addr = 0x329;
        field { sw = r; hw = r; reset = 0x40; } value[31:0];
    } mhpmevent9 @ 0xA8;

    reg {
        // mhpmcounter10 — event counter: instr_ret_compressed (compressed instructions retired).
        riscv_csr_addr = 0xB0A;
        field { sw = rw; hw = r; reset = 0x0;
                riscv_hw_increment_when = "hpm10_inc_en"; } value[31:0];
    } mhpmcounter10 @ 0x5C;

    reg {
        // mhpmcounter10h — high half, links via
        // `riscv_hw_increment_high_of`.
        riscv_csr_addr = 0xB8A;
        field { sw = rw; hw = r; reset = 0x0;
                riscv_hw_increment_high_of = "mhpmcounter10"; } value[31:0];
    } mhpmcounter10h @ 0x84;

    reg {
        // mhpmevent10 — RO selector; reads 0x80
        // (Ibex hardwires event = 1 << (counter_idx - 3)).
        riscv_csr_addr = 0x32A;
        field { sw = r; hw = r; reset = 0x80; } value[31:0];
    } mhpmevent10 @ 0xAC;

    reg {
        // mhpmcounter11 — event counter: mul_wait (cycles waiting for multiply).
        riscv_csr_addr = 0xB0B;
        field { sw = rw; hw = r; reset = 0x0;
                riscv_hw_increment_when = "hpm11_inc_en"; } value[31:0];
    } mhpmcounter11 @ 0x60;

    reg {
        // mhpmcounter11h — high half, links via
        // `riscv_hw_increment_high_of`.
        riscv_csr_addr = 0xB8B;
        field { sw = rw; hw = r; reset = 0x0;
                riscv_hw_increment_high_of = "mhpmcounter11"; } value[31:0];
    } mhpmcounter11h @ 0x88;

    reg {
        // mhpmevent11 — RO selector; reads 0x100
        // (Ibex hardwires event = 1 << (counter_idx - 3)).
        riscv_csr_addr = 0x32B;
        field { sw = r; hw = r; reset = 0x100; } value[31:0];
    } mhpmevent11 @ 0xB0;

    reg {
        // mhpmcounter12 — event counter: div_wait (cycles waiting for divide).
        riscv_csr_addr = 0xB0C;
        field { sw = rw; hw = r; reset = 0x0;
                riscv_hw_increment_when = "hpm12_inc_en"; } value[31:0];
    } mhpmcounter12 @ 0x64;

    reg {
        // mhpmcounter12h — high half, links via
        // `riscv_hw_increment_high_of`.
        riscv_csr_addr = 0xB8C;
        field { sw = rw; hw = r; reset = 0x0;
                riscv_hw_increment_high_of = "mhpmcounter12"; } value[31:0];
    } mhpmcounter12h @ 0x8C;

    reg {
        // mhpmevent12 — RO selector; reads 0x200
        // (Ibex hardwires event = 1 << (counter_idx - 3)).
        riscv_csr_addr = 0x32C;
        field { sw = r; hw = r; reset = 0x200; } value[31:0];
    } mhpmevent12 @ 0xB4;
};
