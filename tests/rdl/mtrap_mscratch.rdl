// Phase-6.5a minimal CSR fixture — just mscratch.
//
// Used as the first swap-in target: drives our generated `CsrFile`
// module to back Ibex's mscratch storage, while every other M-trap
// CSR stays in the forked `ibex_cs_registers_hybrid.sv`. Subsequent
// sub-phases will graduate to the full `mtrap_subset.rdl` fixture as
// more CSRs get routed through our generator.

addrmap m_trap_mscratch {
    default riscv_priv = "m";

    reg {
        riscv_csr_addr = 0x340;
        field { sw = rw; hw = r; reset = 0x0; } value[31:0];
    } mscratch @ 0x0;
};
